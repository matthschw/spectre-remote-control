//input.scs
global 0

parameters r1=1k r2=2k c1=1p vi=1

save I O V0:p R1:1
V0 (I 0) vsource type=dc mag=1 dc=vi
R0 (I O) resistor r=r1
C0 (O 0) fuubar c=c1 ic=0
R1 (O 0) resistor r=r2

options options rforce=1m bin_relref=yes soa_dest=file check_format=test

dc1 dc
dc2 dc param=vi start=0 stop=10
ac ac start=1 stop=1G
tran tran stop=5n
