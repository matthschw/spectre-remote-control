`include "constants.vams"
`include "disciplines.vams"

module ideal_opamp(inp,inn,out,VDD,VSS);

  input inp,inn;
  output out;
  inout VDD,VSS;

  electrical inp,inn,out,VDD,VSS;

  real parameter IDD=1u;

  analog begin

    V(out) : V(inp,inn) == 0 ;

    I(VDD,VSS) <+ IDD;

  end
endmodule
